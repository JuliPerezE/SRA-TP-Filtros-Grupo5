* C:\Users\ferok\UNIVERSIDAD\Sintesis de Redes activas\Laboratorios\LAB2_filtros\Simulaciones\PasaBajos_Bessel_IDEAL\PasaBajos_Bessel_orden3_IDEAL.asc
* Generated by LTspice 26.1.1 for Windows.
X§U1 N002 N003 +V -V N003 ADTL082 ;§pnba In+)In-)V+)V-)OUT
X§U2 N004 Vout +V -V Vout ADTL082 ;§pnba In+)In-)V+)V-)OUT
V1 +V 0 15
V2 -V 0 -15
R0 N002 Vin 16.9k
C0 N002 0 10n
R1 N001 N003 6.8k
R2 N004 N001 16k
C1 Vout N001 22n
C2 0 N004 10n
Vin Vin 0 PULSE(0 1 10m 1n 1n 200m 400m 0) AC 1
;.ac dec 100 1 10k
* AC Analisis de Barrido Frec
* Analisis Transitorio
.tran 20m startup
* Library below included based on ModelFile attribute of instance X§U1, X§U2 (C:\Users\ferok\AppData\Local\LTspice\lib\sym\OpAmps\ADTL082.asy)
.lib ADI.lib
.backanno
.end
