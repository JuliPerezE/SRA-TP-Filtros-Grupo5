* C:\Users\ferok\UNIVERSIDAD\Sintesis de Redes activas\Laboratorios\LAB2_filtros\Simulaciones\PasaBajos_Bessel_IDEAL_BARRIDO\PasaBajos_Bessel_orden3_IDEAL_BARRIDO.asc
* Generated by LTspice 26.1.1 for Windows.
V1 +V 0 15
V2 -V 0 -15
R0 N002 Vin {mc(16.9k,tol1)}
C0 N002 0 {mc(10n,tol10)}
R1 N001 N003 {mc(6.8k,tol5)}
R2 N004 N001 {mc(16k,tol5)}
C1 Vout N001 {mc(22n,tol10)}
C2 0 N004 {mc(10n,tol10)}
Vin Vin 0 PULSE(0 1 10m 1n 1n 25m 30m 0) AC 1
X§U1 N002 N003 +V -V N003 TL082 ;§pnba 1)2)3)4)5
X§U2 N004 Vout +V -V Vout TL082 ;§pnba 1)2)3)4)5
.tran 20m
* AC Analisis de Barrido Frec
* .ac dec 100 1 10k
.param tol5=0.05
.param tol1=0.01
* Tolerancias de comp.
.step param run 1 100 1
* Hacer 100 simu con Montecarlo
.include TL082.301
.param tol10=0.1
;.meas AC Salida_dB FIND mag(V(vout)) AT 4k
.meas TRAN Salida_10.91ms FIND V(vout) AT 10.91m
* Library below included based on ModelFile attribute of instance X§U1, X§U2 (C:\Users\ferok\UNIVERSIDAD\Sintesis de Redes activas\Laboratorios\LAB2_filtros\Simulaciones\PasaBajos_Bessel_IDEAL_BARRIDO\TL082.asy)
.lib TL082.301
.backanno
.end
